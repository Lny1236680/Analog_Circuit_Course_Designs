** 0_light_tracker_X_axis **
*
* NI Multisim to SPICE Netlist Export
* Generated by: multisim-sim
*
* 点光源跟踪器 — 单轴(X)传感+差动放大+滞回比较电路
* 链路: LDR分压(左/右) -> LM358差动放大(K_a=10) -> LM393滞回比较 -> Vout_COMP (接 TB6612 AIN1/AIN2)
*
* 节点:
*   0   = GND
*   VCC = 5V 电源
*   1   = 左光敏分压点 AO_L   (LM393+5516 光敏模块 AO 输出)
*   2   = 右光敏分压点 AO_R   (LM393+5516 光敏模块 AO 输出)
*   3   = 差动输出 Vout_X     (LM358, 单电源饱和 0~5V)
*   4   = LM358 反相输入(-)
*   5   = LM358 同相输入(+)
*   6   = LM393 同相输入(+)   (Vout_X 经 R3 + 滞回反馈 Rhys 求和点)
*   7   = LM393 反相输入(-)   (R7/R8 分压基准 2.5V)
*   8   = LM393 开漏输出 Vout_COMP (上拉至 VCC, 接 TB6612 AIN1/AIN2)
*

*## Multisim Component VCC ##*
VCCVCC VCC 0 dc 5

*--- 传感级: LM393+5516 光敏电阻模块 (取 AO 模拟输出, 模块内部分压) ---*
* 光照越强 LDR 阻值越小 (5506 暗 50K~亮 2K); AO = VCC*Rldr/(R1+Rldr)

*## Multisim Component R1 (左光敏模块分压上拉, 模块内 R1=10K) ##*
rR1 VCC 1 10000 vresR1
.model vresR1 r(  )

*## Multisim Component LDR_L (左光敏电阻 5516, 模块内) ##*
* 用电阻模拟: 光照弱(暗) R=50K, 光照强(亮) R=2K
* 此处设中间值 R=10K 演示差分 (V_AO_L=2.5V)
rLDRL 1 0 10000 vresLDRL
.model vresLDRL r(  )

*## Multisim Component R2 (右光敏模块分压上拉, 模块内 R1=10K) ##*
rR2 VCC 2 10000 vresR2
.model vresR2 r(  )

*## Multisim Component LDR_R (右光敏电阻 5516, 模块内) ##*
* 设 R=2K 模拟"光源偏右, 右更亮" (V_AO_R=0.833V)
rLDRR 2 0 2000 vresLDRR
.model vresLDRR r(  )

*--- 差动放大级: LM358 ---*
* Vout_X = (Rf/Rin)*(V_AO_R - V_AO_L) = 10*(V_AO_R - V_AO_L)

*## Multisim Component Rin_L (差动反相输入电阻) ##*
rRinL 1 4 10000 vresRinL
.model vresRinL r(  )

*## Multisim Component Rin_R (差动同相输入电阻) ##*
rRinR 2 5 10000 vresRinR
.model vresRinR r(  )

*## Multisim Component Rm (匹配电阻) ##*
rRm 5 0 10000 vresRm
.model vresRm r(  )

*## Multisim Component Rf (反馈电阻) ##*
rRf 4 3 100000 vresRf
.model vresRf r(  )

*## Multisim Component U1 (LM358 双运放, 用通用运放子电路) ##*
xU1 4 5 3 0 VCC LM358__OPAMP__1

*--- 滞回比较级: LM393 (开漏), 把 Vout_X 转成 H/L 驱动电平 ---*
* Vref=2.5V; Vout_X>Vref 时输出 HIGH, Vout_X<Vref 时输出 LOW
* Rhys 提供正反馈滞回 (约 ±0.25V), 避免零点附近抖振

*## Multisim Component R3 (比较器输入电阻, Vout_X -> in+) ##*
rR3 3 6 10000 vresR3
.model vresR3 r(  )

*## Multisim Component Rhys (滞回反馈电阻, out -> in+) ##*
rRhys 8 6 100000 vresRhys
.model vresRhys r(  )

*## Multisim Component R7 (基准分压上电阻, 2.5V) ##*
rR7 VCC 7 10000 vresR7
.model vresR7 r(  )

*## Multisim Component R8 (基准分压下电阻) ##*
rR8 7 0 10000 vresR8
.model vresR8 r(  )

*## Multisim Component Rpull (开漏输出上拉) ##*
rRpull VCC 8 10000 vresRpull
.model vresRpull r(  )

*## Multisim Component U2 (LM393 比较器, 开漏输出) ##*
xU2 7 6 8 0 VCC LM393__COMPARATOR__1

*--- 简化宏模型 ---*
* LM358 运放子电路 (增益 100k + 饱和限幅, 单电源)
.SUBCKT LM358__OPAMP__1 1 2 3 4 5
* 1=in- 2=in+ 3=out 4=V- 5=V+
* 简化宏模型: 差动输入 -> 单极点增益 100k, 饱和限幅
Rin 1 2 2Meg
Eop 6 0 2 1 100000
Rout 6 3 1
Cout 3 0 10n
Dn 3 4 DN
Dp 5 3 DP
.MODEL DN D(IS=1e-15)
.MODEL DP D(IS=1e-15)
.ENDS

* LM393 比较器子电路 (开漏输出, 简化宏模型: 高增益差动 + 钳位)
* 注: 真实 LM393 为开漏, 高电平靠外部上拉 Rpull 提供; 此处用钳位宏模型
*     近似, Multisim 导入时可能提示替换成库内元件, 属正常现象。
.SUBCKT LM393__COMPARATOR__1 1 2 3 4 5
* 1=in- 2=in+ 3=out(开漏) 4=V- 5=V+
Rin 1 2 2Meg
Ecmp 6 0 2 1 200000
Rout 6 3 1
Dn 3 4 DN
Dp 5 3 DP
.MODEL DN D(IS=1e-15)
.MODEL DP D(IS=1e-15)
.ENDS

* 仿真控制 (Multisim 导入忽略, 便于 ngspice/其他 SPICE 验证):
* .op
* .dc VCC 0 5 0.1
* .end
